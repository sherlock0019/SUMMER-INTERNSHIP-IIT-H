# Ansys Electronics Desktop project, version 2020.2
materials:
  M19_24G: permeability{HUnit=A_per_meter BUnit=tesla curve (0, 0) (22.28, 0.05) (25.46, 0.1) (31.83, 0.15) (47.74, 0.36) (63.66, 0.54) (79.57, 0.65) (159.15, 0.99) (318.3, 1.2) (477.46, 1.28) (636.61, 1.33) (795.77, 1.36) (1591.5, 1.44) (3183, 1.52) (4774.6, 1.58) (6366.1, 1.63) (7957.7, 1.67) (15915, 1.8) (31830, 1.9) (111407, 2) (190984, 2.1) (350138, 2.3) (509292, 2.5)} conductivity=1960000 core_loss_type="Electrical Steel" core_loss_kh=164.2 core_loss_kc=1.3 core_loss_ke=1.72 mass_density=7650
  cast_aluminum_75C: permeability=1.000021 conductivity=23000000
  vacuum: permittivity=1
  M19_24G_2DSF0.920: permeability{HUnit=A_per_meter BUnit=tesla curve (0, 0) (22.28, 0.0460022) (25.46, 0.0920026) (31.83, 0.138003) (47.74, 0.331205) (63.66, 0.496806) (79.57, 0.598008) (159.15, 0.910816) (318.3, 1.10403) (477.46, 1.17765) (636.61, 1.22366) (795.77, 1.25128) (1591.5, 1.32496) (3183, 1.39872) (4774.6, 1.45408) (6366.1, 1.50024) (7957.7, 1.5372) (15915, 1.6576) (31830, 1.7512) (111407, 1.8512) (190984, 1.9512) (350138, 2.1512) (509292, 2.3512) (2100830, 4.3512)} conductivity=1960000 core_loss_type="Electrical Steel" core_loss_kh=178.478 core_loss_kc=1.41304 core_loss_ke=1.79322 mass_density=7038
  copper: permeability=0.999991 conductivity=58000000 mass_density=8933

design Maxwell2DDesign1 (Maxwell 2D, Transient, XY geometry, model units mm)
options: ModelDepth=280mm
variables:
  fractions = 1
geometry:
  Band [vacuum] = user_primitive(RMxprt/Band, DiaGap=209.75mm, DiaYoke=75mm, Length=0mm, SegAngle=0deg, Fractions=1, HalfAxial=0, InfoCore=0)
  Shaft [vacuum] = user_primitive(RMxprt/Band, DiaGap=209.75mm, DiaYoke=75mm, Length=0mm, SegAngle=0deg, Fractions=1, HalfAxial=0, InfoCore=100)
  OuterRegion [vacuum] = user_primitive(RMxprt/Band, DiaGap=209.75mm, DiaYoke=327mm, Length=0mm, SegAngle=0deg, Fractions=fractions, HalfAxial=0, InfoCore=100)
  Tool = user_primitive(RMxprt/Band, DiaGap=209.75mm, DiaYoke=327mm, Length=0mm, SegAngle=0deg, Fractions=fractions, HalfAxial=0, InfoCore=1)
  Stator [M19_24G_2DSF0.920] = user_primitive(RMxprt/SlotCore, DiaGap=210mm, DiaYoke=327mm, Length=0mm, Skew=0deg, Slots=36, SlotType=2, Hs0=0.8mm, Hs01=0mm, Hs1=0.52mm, Hs2=39.48mm, Bs0=3mm, Bs1=4.8mm, Bs2=8.2mm, Rs=4.1mm, FilletType=0, HalfSlot=0, SegAngle=15deg, LenRegion=0mm, InfoCore=0)
  Coil_0 [copper] = user_primitive(RMxprt/LapCoil, DiaGap=210mm, DiaYoke=327mm, Length=0mm, Skew=0deg, Slots=36, SlotType=2, Hs0=0.8mm, Hs1=0.52mm, Hs2=39.48mm, Bs0=3mm, Bs1=4.8mm, Bs2=8.2mm, Rs=4.1mm, FilletType=0, Layers=1, CoilPitch=3, EndExt=0mm, SpanExt=0mm, BendAngle=0deg, SegAngle=10deg, LenRegion=0mm, InfoCoil=2)
  Coil_1..Coil_35 [copper] = Coil_0.duplicate_around_axis(axis=Z, angle=10deg, total=36)
  Rotor [M19_24G_2DSF0.920] = user_primitive(RMxprt/SlotCore, DiaGap=209.5mm, DiaYoke=75mm, Length=0mm, Skew=0deg, Slots=49, SlotType=2, Hs0=0.5mm, Hs01=0mm, Hs1=0.66mm, Hs2=14.34mm, Bs0=1mm, Bs1=3.3mm, Bs2=3.3mm, Rs=0mm, FilletType=0, HalfSlot=0, SegAngle=15deg, LenRegion=0mm, InfoCore=0)
  Bar [cast_aluminum_75C] = user_primitive(RMxprt/SquirrelCage, DiaGap=209.5mm, DiaYoke=75mm, Length=0mm, Skew=0deg, Slots=49, SlotType=2, Hs0=0.5mm, Hs01=0mm, Hs1=0.66mm, Hs2=14.34mm, Bs0=1mm, Bs1=3.3mm, Bs2=3.3mm, Rs=0mm, FilletType=0, HalfSlot=0, BarEndExt=0mm, RingLength=40mm, RingHeight=16mm, RingDiaGap=0mm, CastRotor=1, SegAngle=15deg, LenRegion=0mm, InfoCoil=0)
  Tool_1 = Tool.copy()
  Bar.subtract(Tool_1)
  Bar_Separate1..Bar_Separate48 [cast_aluminum_75C] = Bar.separate_bodies()
  InnerRegion [vacuum] = user_primitive(RMxprt/SlotCore, DiaGap=209.5mm, DiaYoke=75mm, Length=0mm, Skew=0deg, Slots=49, SlotType=2, Hs0=0.5mm, Hs01=0mm, Hs1=0.66mm, Hs2=14.34mm, Bs0=1mm, Bs1=3.3mm, Bs2=3.3mm, Rs=0mm, FilletType=0, HalfSlot=0, SegAngle=15deg, LenRegion=0mm, InfoCore=100)
  Tool_2 = Tool.copy()
  Band.subtract(Tool_2)
  Tool_3 = Tool.copy()
  InnerRegion.subtract(Tool_3)
  Tool_4 = Tool.copy()
  Shaft.subtract(Tool_4)
  Tool_5 = Tool.copy()
  Stator.subtract(Tool_5)
  Tool_6 = Tool.copy()
  Coil_0.subtract(Tool_6)
  Tool_7 = Tool.copy()
  Coil_1.subtract(Tool_7)
  Tool_8 = Tool.copy()
  Coil_2.subtract(Tool_8)
  Tool_9 = Tool.copy()
  Coil_3.subtract(Tool_9)
  Tool_10 = Tool.copy()
  Coil_4.subtract(Tool_10)
  Tool_11 = Tool.copy()
  Coil_5.subtract(Tool_11)
  Tool_12 = Tool.copy()
  Coil_6.subtract(Tool_12)
  Tool_13 = Tool.copy()
  Coil_7.subtract(Tool_13)
  Tool_14 = Tool.copy()
  Coil_8.subtract(Tool_14)
  Tool_15 = Tool.copy()
  Coil_9.subtract(Tool_15)
  Tool_16 = Tool.copy()
  Coil_10.subtract(Tool_16)
  Tool_17 = Tool.copy()
  Coil_11.subtract(Tool_17)
  Tool_18 = Tool.copy()
  Coil_12.subtract(Tool_18)
  Tool_19 = Tool.copy()
  Coil_13.subtract(Tool_19)
  Tool_20 = Tool.copy()
  Coil_14.subtract(Tool_20)
  Tool_21 = Tool.copy()
  Coil_15.subtract(Tool_21)
  Tool_22 = Tool.copy()
  Coil_16.subtract(Tool_22)
  Tool_23 = Tool.copy()
  Coil_17.subtract(Tool_23)
  Tool_24 = Tool.copy()
  Coil_18.subtract(Tool_24)
  Tool_25 = Tool.copy()
  Coil_19.subtract(Tool_25)
  Tool_26 = Tool.copy()
  Coil_20.subtract(Tool_26)
  Tool_27 = Tool.copy()
  Coil_21.subtract(Tool_27)
  Tool_28 = Tool.copy()
  Coil_22.subtract(Tool_28)
  Tool_29 = Tool.copy()
  Coil_23.subtract(Tool_29)
  Tool_30 = Tool.copy()
  Coil_24.subtract(Tool_30)
  Tool_31 = Tool.copy()
  Coil_25.subtract(Tool_31)
  Tool_32 = Tool.copy()
  Coil_26.subtract(Tool_32)
  Tool_33 = Tool.copy()
  Coil_27.subtract(Tool_33)
  Tool_34 = Tool.copy()
  Coil_28.subtract(Tool_34)
  Tool_35 = Tool.copy()
  Coil_29.subtract(Tool_35)
  Tool_36 = Tool.copy()
  Coil_30.subtract(Tool_36)
  Tool_37 = Tool.copy()
  Coil_31.subtract(Tool_37)
  Tool_38 = Tool.copy()
  Coil_32.subtract(Tool_38)
  Tool_39 = Tool.copy()
  Coil_33.subtract(Tool_39)
  Tool_40 = Tool.copy()
  Coil_34.subtract(Tool_40)
  Tool_41 = Tool.copy()
  Coil_35.subtract(Tool_41)
  Rotor.subtract(Tool)
motion:
  MotionSetup1: Band Move_Type=Rotate Coordinate_System=Global Axis=Z Is_Positive=true InitPos=0deg Angular_Velocity=0rpm Moment_of_Inertia=0.00113855 Damping=0.2 Load_Torque=-20NewtonMeter Objects=Band
  Moving1: Moving Objects=[Shaft, Rotor, Bar, Bar_Separate1..Bar_Separate48, InnerRegion]
boundaries and excitations:
  VectorPotential1: Vector Potential Edges=OuterRegion.edge(at (0, 163.5, 0)) Value=0
  0: Coil Objects=Coil_0 Conductor_number=24 Winding=Winding1 PolarityType=Positive
  3: Coil Objects=Coil_3 Conductor_number=24 Winding=Winding7 PolarityType=Negative
  2: Coil Objects=Coil_2 Conductor_number=24 Winding=Winding2 PolarityType=Positive
  5: Coil Objects=Coil_5 Conductor_number=24 Winding=Winding8 PolarityType=Negative
  4: Coil Objects=Coil_4 Conductor_number=24 Winding=Winding3 PolarityType=Positive
  7: Coil Objects=Coil_7 Conductor_number=24 Winding=Winding9 PolarityType=Negative
  6: Coil Objects=Coil_6 Conductor_number=24 Winding=Winding4 PolarityType=Positive
  9: Coil Objects=Coil_9 Conductor_number=24 Winding=Winding1 PolarityType=Negative
  8: Coil Objects=Coil_8 Conductor_number=24 Winding=Winding5 PolarityType=Positive
  11: Coil Objects=Coil_11 Conductor_number=24 Winding=Winding2 PolarityType=Negative
  10: Coil Objects=Coil_10 Conductor_number=24 Winding=Winding6 PolarityType=Positive
  13: Coil Objects=Coil_13 Conductor_number=24 Winding=Winding3 PolarityType=Negative
  12: Coil Objects=Coil_12 Conductor_number=24 Winding=Winding7 PolarityType=Positive
  15: Coil Objects=Coil_15 Conductor_number=24 Winding=Winding4 PolarityType=Negative
  14: Coil Objects=Coil_14 Conductor_number=24 Winding=Winding8 PolarityType=Positive
  17: Coil Objects=Coil_17 Conductor_number=24 Winding=Winding5 PolarityType=Negative
  16: Coil Objects=Coil_16 Conductor_number=24 Winding=Winding9 PolarityType=Positive
  19: Coil Objects=Coil_19 Conductor_number=24 Winding=Winding6 PolarityType=Negative
  18: Coil Objects=Coil_18 Conductor_number=24 Winding=Winding1 PolarityType=Positive
  21: Coil Objects=Coil_21 Conductor_number=24 Winding=Winding7 PolarityType=Negative
  20: Coil Objects=Coil_20 Conductor_number=24 Winding=Winding2 PolarityType=Positive
  23: Coil Objects=Coil_23 Conductor_number=24 Winding=Winding8 PolarityType=Negative
  22: Coil Objects=Coil_22 Conductor_number=24 Winding=Winding3 PolarityType=Positive
  25: Coil Objects=Coil_25 Conductor_number=24 Winding=Winding9 PolarityType=Negative
  24: Coil Objects=Coil_24 Conductor_number=24 Winding=Winding4 PolarityType=Positive
  27: Coil Objects=Coil_27 Conductor_number=24 Winding=Winding1 PolarityType=Negative
  26: Coil Objects=Coil_26 Conductor_number=24 Winding=Winding5 PolarityType=Positive
  29: Coil Objects=Coil_29 Conductor_number=24 Winding=Winding2 PolarityType=Negative
  28: Coil Objects=Coil_28 Conductor_number=24 Winding=Winding6 PolarityType=Positive
  31: Coil Objects=Coil_31 Conductor_number=24 Winding=Winding3 PolarityType=Negative
  30: Coil Objects=Coil_30 Conductor_number=24 Winding=Winding7 PolarityType=Positive
  33: Coil Objects=Coil_33 Conductor_number=24 Winding=Winding4 PolarityType=Negative
  32: Coil Objects=Coil_32 Conductor_number=24 Winding=Winding8 PolarityType=Positive
  35: Coil Objects=Coil_35 Conductor_number=24 Winding=Winding5 PolarityType=Negative
  34: Coil Objects=Coil_34 Conductor_number=24 Winding=Winding9 PolarityType=Positive
  1: Coil Objects=Coil_1 Conductor_number=24 Winding=Winding6 PolarityType=Negative
  EndConnection1: End Connection Objects=[Bar, Bar_Separate1..Bar_Separate48] ResistanceValue=8.38449e-07ohm InductanceValue=5.33218e-09H
  Winding1: Winding Group Type=Voltage IsSolid=false Current=0mA Resistance=0.731967ohm Inductance=0.00360115H Voltage=195.633*sin(2*pi*50*time) ParallelBranchesNum=1
  Winding2: Winding Group Type=Voltage IsSolid=false Current=0mA Resistance=0.731967ohm Inductance=0.00360115H Voltage=195.633*sin(2*pi*50*time-2*pi/9) ParallelBranchesNum=1
  Winding3: Winding Group Type=Voltage IsSolid=false Current=0mA Resistance=0.731967ohm Inductance=0.00360115H Voltage=195.633*sin(2*pi*50*time-4*pi/9) ParallelBranchesNum=1
  Winding4: Winding Group Type=Voltage IsSolid=false Current=0mA Resistance=0.731967ohm Inductance=0.00360115H Voltage=195.633*sin(2*pi*50*time-6*pi/9) ParallelBranchesNum=1
  Winding5: Winding Group Type=Voltage IsSolid=false Current=0mA Resistance=0.731967ohm Inductance=0.00360115H Voltage=195.633*sin(2*pi*50*time-8*pi/9) ParallelBranchesNum=1
  Winding6: Winding Group Type=Voltage IsSolid=false Current=0mA Resistance=0.731967ohm Inductance=0.00360115H Voltage=195.633*sin(2*pi*50*time-10*pi/9) ParallelBranchesNum=1
  Winding7: Winding Group Type=Voltage IsSolid=false Current=0mA Resistance=0.731967ohm Inductance=0.00360115H Voltage=195.633*sin(2*pi*50*time-12*pi/9) ParallelBranchesNum=1
  Winding8: Winding Group Type=Voltage IsSolid=false Current=0mA Resistance=0.731967ohm Inductance=0.00360115H Voltage=195.633*sin(2*pi*50*time-14*pi/9) ParallelBranchesNum=1
  Winding9: Winding Group Type=Voltage IsSolid=false Current=0mA Resistance=0.731967ohm Inductance=0.00360115H Voltage=195.633*sin(2*pi*50*time-16*pi/9) ParallelBranchesNum=1
mesh:
  SurfApprox_Bar: SurfApproxBased Objects=[Bar, Bar_Separate1..Bar_Separate48] CurvedSurfaceApproxChoice=ManualSettings SurfDev=0.10475mm NormalDev=15deg
  SurfApprox_Main: SurfApproxBased Objects=[Stator, Rotor, Band, OuterRegion, InnerRegion, Shaft] CurvedSurfaceApproxChoice=ManualSettings SurfDev=0.1635mm NormalDev=15deg
  initial mesh: MeshMethod=AnsoftTAU
setups:
  Setup1: Transient NonlinearSolverResidual=0.0001 StopTime=1s TimeStep=0.0002s FastReachSteadyState AutoDetectSteadyState FrequencyOfAddedVoltageSource=50Hz StopCriterion=0.0005 SaveFieldsType=Custom SweepRanges{0s to 1s step 0.0002s} NumberSolveSteps=1 RangeStart=0s RangeEnd=0.1s InitialTimeStep=0.002s MinTimeStep=0.001s MaxTimeStep=0.003s TimeStepErrTolerance=0.0001
field plots:
  Flux_Lines1: A over Band, Shaft, OuterRegion, Stator, Coil_0..Coil_35, Rotor, Bar, Bar_Separate1..Bar_Separate48, InnerRegion on Setup1 : Transient at Time=-1
  Mag_H1: H over Band, Shaft, OuterRegion, Stator, Coil_0..Coil_35, Rotor, Bar, Bar_Separate1..Bar_Separate48, InnerRegion on Setup1 : Transient at Time=-1
reports:
  Torque: Moving1.Torque vs Time on Setup1 : Transient
  Powers: InputVoltage(PhaseA)*Current(PhaseA) + InputVoltage(PhaseB)*Current(PhaseB) + InputVoltage(PhaseC)*Current(PhaseC), Moving1.Speed*Moving1.Torque vs Time on Setup1 : Transient
  Speed Plot 1: Moving1.Speed vs Time on Setup1 : Transient
  Flux linkage: FluxLinkage(Winding1), FluxLinkage(Winding2), FluxLinkage(Winding3), FluxLinkage(Winding4), FluxLinkage(Winding5), FluxLinkage(Winding6), FluxLinkage(Winding7), FluxLinkage(Winding8), FluxLinkage(Winding9) vs Time on Setup1 : Transient
  induced voltage: InducedVoltage(Winding1), InducedVoltage(Winding2), InducedVoltage(Winding3), InducedVoltage(Winding4), InducedVoltage(Winding5), InducedVoltage(Winding6), InducedVoltage(Winding7), InducedVoltage(Winding8), InducedVoltage(Winding9) vs Time on Setup1 : Transient
  voltage: InputVoltage(Winding1), InputVoltage(Winding2), InputVoltage(Winding3), InputVoltage(Winding4), InputVoltage(Winding5), InputVoltage(Winding6), InputVoltage(Winding7), InputVoltage(Winding8), InputVoltage(Winding9) vs Time on Setup1 : Transient
  currents: Current(Winding1), Current(Winding2), Current(Winding3), Current(Winding4), Current(Winding5), Current(Winding6), Current(Winding7), Current(Winding8), Current(Winding9) vs Time on Setup1 : Transient

design IM3-12 (RMxprt, Three Phase Induction Motor, model units mm)
machine:
  Machine: FrictionLoss=7W WindLoss=0W ReferenceSpeed=500rpm NumberOfPoles=12 StrayLossFactor=0.005
  Stator: SkewWidth=0 NumberOfSlots=36 LaminationSectors=0 PressBoardThickness=0mm OuterDiameter=327mm InnerDiameter=210mm Length=280mm StackingFactor=0.92 SteelType=M19_24G SlotType=2
  Rotor: OuterDiameter=209.5mm InnerDiameter=75mm Length=280mm SteelType=M19_24G NumberOfSlots=49 SlotType=2 SkewWidth=0 CastRotor BottomSlotType=2 StackingFactor=0.92
  Shaft:
  Stator Slot: Hs0=0.8mm Hs1=0.52mm Hs2=39.48mm Bs0=3mm Bs1=4.8mm Bs2=8.2mm Rs=0mm ToothWidth=0mm
  Stator Winding: WindingType=Whole-Coiled WindingLayers=1 ParallelBranches=1 ConductorsPerSlot=24 CoilPitch=3 EndAdjustment=0mm BaseInnerRadius=0mm TipInnerDiameter=0mm EndClearance=0mm CoilWrap=0mm SlotLiner=0.3mm WedgeThickness=0mm LayerInsulation=0mm BottomInsulation=0mm LimitedFillFactor=0.75 WdgNumberofPriodicMultipler=1 NumberOfStrands=4 WireWrap=0.09mm InterturnInsulation=0mm WireDiameter=1.12mm WireWidth=0mm WireThickness=0mm Gauge=USER
  Rotor Slot: Hs0=0.5mm Hs1=0.66mm Hs2=14.34mm Bs0=1mm Bs1=3.3mm Bs2=3.3mm Rs=0mm Hs01=0mm
  Rotor Winding: BarConductorType=cast_aluminum_75C EndLength=0mm EndRingWidth=40mm EndRingHeight=16mm EndRingConductorType=cast_aluminum_75C
setups:
  Setup1: TPIM Motor RatedOutputPower=5000W RatedVoltage=415V RatedSpeed=495rpm OperatingTemperature=75cel LoadType=ConstPower Frequency=50Hz WindingConnection=0
