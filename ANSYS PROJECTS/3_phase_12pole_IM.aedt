# Ansys Electronics Desktop project, version 2021.2
materials:
  steel_1008: permeability{HUnit=A_per_meter BUnit=tesla curve (0, 0) (159.2, 0.2402) (318.3, 0.8654) (477.5, 1.1106) (636.6, 1.2458) (795.8, 1.331) (1591.5, 1.5) (3183.1, 1.6) (4774.6, 1.683) (6366.2, 1.741) (7957.7, 1.78) (15915.5, 1.905) (31831, 2.025) (47746.5, 2.085) (63662, 2.13) (79577.5, 2.165) (159155, 2.28) (318310, 2.485) (397887, 2.5851)} conductivity=4000000 mass_density=7872
  aluminum_no2_EC: permeability=1.000021 conductivity=33000000
  copper: permeability=0.999991 conductivity=58000000 mass_density=8933
  molybdenum: conductivity=17600000 mass_density=10220
  nickel: permeability=600 conductivity=14500000 mass_density=8900
  iron: permeability=4000 conductivity=10300000 mass_density=7870
  aluminum: permeability=1.000021 conductivity=38000000 mass_density=2689
  ferrite: permittivity=12 permeability=1000 conductivity=0.01 mass_density=4600
  steel_1009: permeability{HUnit=A_per_meter BUnit=tesla curve } conductivity=4000000 mass_density=7872
  magnesium: conductivity=2250000 mass_density=1746
  steel_stainless: conductivity=110000 mass_density=8055

design RMxprtDesign1 (RMxprt, Three Phase Induction Motor, model units mm)
machine:
  Machine: FrictionLoss=12.5W WindLoss=12.5W ReferenceSpeed=500rpm NumberOfPoles=12 StrayLossFactor=0.005
  Stator: SkewWidth=0 NumberOfSlots=36 LaminationSectors=1 PressBoardThickness=5mm OuterDiameter=800mm InnerDiameter=650mm Length=650mm StackingFactor=0.97 SteelType=steel_1008 SlotType=4
  Rotor: OuterDiameter=649mm InnerDiameter=200mm Length=650mm SteelType=steel_1008 NumberOfSlots=61 SlotType=2 SkewWidth=0 CastRotor BottomSlotType=UserDefinedSlot StackingFactor=0.97
  Shaft: MagneticShaft
  Stator Slot: Hs0=0.8mm Hs1=0.58mm Hs2=10mm Bs0=3mm Bs1=8.8mm Bs2=12.6mm Rs=6.3mm ToothWidth=0mm
  Stator Winding: WindingType=Whole-Coiled WindingLayers=1 ParallelBranches=6 ConductorsPerSlot=39 CoilPitch=13 EndAdjustment=0mm BaseInnerRadius=0mm TipInnerDiameter=0mm EndClearance=0mm CoilWrap=0mm SlotLiner=0mm WedgeThickness=0mm LayerInsulation=0mm BottomInsulation=0mm LimitedFillFactor=0.75 WdgNumberofPriodicMultipler=1 NumberOfStrands=36 WireWrap=5mm InterturnInsulation=0mm WireDiameter=2mm WireWidth=0mm WireThickness=0mm Gauge=0
  Rotor Slot: Hs0=0.5mm Hs1=0.66mm Hs2=10mm Bs0=1mm Bs1=6mm Bs2=6mm Rs=0.5mm Hs01=0mm
  Rotor Winding: BarConductorType=magnesium EndLength=0mm EndRingWidth=75mm EndRingHeight=30mm EndRingConductorType=magnesium
  Rotor Vent: VentDucts=0 DuctWidth=0mm MagneticSpacerWidth=0mm DuctPitch=0mm HolesperRow=6 InnerHoleDiameter=30mm OuterHoleDiameter=45mm InnerHoleLocation=300mm OuterHoleLocation=400mm
setups:
  Setup1: TPIM Motor RatedOutputPower=6kW RatedVoltage=230V RatedSpeed=490rpm OperatingTemperature=40cel LoadType=ConstPower Frequency=50Hz WindingConnection=0
reports:
  Torque: OutputTorque vs RSpeed on Setup1 : Performance
  Percentage: Efficiency vs RSpeed on Setup1 : Performance
