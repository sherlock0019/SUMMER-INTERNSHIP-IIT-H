# Ansys Electronics Desktop project, version 2021.2
materials:
  steel_1008: permeability{HUnit=A_per_meter BUnit=tesla curve (0, 0) (159.2, 0.2402) (318.3, 0.8654) (477.5, 1.1106) (636.6, 1.2458) (795.8, 1.331) (1591.5, 1.5) (3183.1, 1.6) (4774.6, 1.683) (6366.2, 1.741) (7957.7, 1.78) (15915.5, 1.905) (31831, 2.025) (47746.5, 2.085) (63662, 2.13) (79577.5, 2.165) (159155, 2.28) (318310, 2.485) (397887, 2.5851)} conductivity=4000000 mass_density=7872
  aluminum_no2_EC: permeability=1.000021 conductivity=33000000
  copper: permeability=0.999991 conductivity=58000000 mass_density=8933
  molybdenum: conductivity=17600000 mass_density=10220
  nickel: permeability=600 conductivity=14500000 mass_density=8900
  iron: permeability=4000 conductivity=10300000 mass_density=7870
  aluminum: permeability=1.000021 conductivity=38000000 mass_density=2689
  ferrite: permittivity=12 permeability=1000 conductivity=0.01 mass_density=4600
  steel_1009: permeability{HUnit=A_per_meter BUnit=tesla curve } conductivity=4000000 mass_density=7872
  magnesium: conductivity=2250000 mass_density=1746
  steel_stainless: conductivity=110000 mass_density=8055
  vacuum: permittivity=1
  steel_1008_2DSF1.009: permeability{HUnit=A_per_meter BUnit=tesla curve (0, 0) (159.2, 0.242281) (318.3, 0.872899) (477.5, 1.12022) (636.6, 1.25659) (795.8, 1.34253) (1591.5, 1.51299) (3183.1, 1.61384) (4774.6, 1.69754) (6366.2, 1.75602) (7957.7, 1.79535) (15915.5, 1.92134) (31831, 2.04221) (47746.5, 2.10256) (63662, 2.14777) (79577.5, 2.1829) (159155, 2.29803) (318310, 2.50308) (397887, 2.60318) (1193660, 3.60419)} conductivity=4000000 mass_density=7940.25
  steel_1008_2DSF0.970: permeability{HUnit=A_per_meter BUnit=tesla curve (0, 0) (159.2, 0.233) (318.3, 0.83945) (477.5, 1.0773) (636.6, 1.20845) (795.8, 1.2911) (1591.5, 1.45506) (3183.1, 1.55212) (4774.6, 1.63269) (6366.2, 1.68901) (7957.7, 1.7269) (15915.5, 1.84845) (31831, 1.96545) (47746.5, 2.02425) (63662, 2.0685) (79577.5, 2.10305) (159155, 2.2176) (318310, 2.42245) (397887, 2.52255) (1193660, 3.52352)} conductivity=4000000 mass_density=7635.84
  magnesium_40C: conductivity=2536360

design RMxprtDesign1 (RMxprt, Three Phase Induction Motor, model units mm)
machine:
  Machine: FrictionLoss=25W WindLoss=450W ReferenceSpeed=500rpm NumberOfPoles=12 StrayLossFactor=0.005
  Stator: SkewWidth=0 NumberOfSlots=36 LaminationSectors=1 PressBoardThickness=5mm OuterDiameter=1150mm InnerDiameter=1000mm Length=258.6mm StackingFactor=0.97 SteelType=steel_1008 SlotType=4
  Rotor: OuterDiameter=999.9mm InnerDiameter=200mm Length=258.6mm SteelType=steel_1008 NumberOfSlots=49 SlotType=2 SkewWidth=0 CastRotor BottomSlotType=UserDefinedSlot StackingFactor=0.97
  Shaft:
  Stator Slot: Hs0=0.8mm Hs1=0.58mm Hs2=18mm Bs0=2mm Bs1=13mm Bs2=19mm Rs=6.33mm ToothWidth=0mm
  Stator Winding: WindingType=Whole-Coiled WindingLayers=1 ParallelBranches=6 ConductorsPerSlot=39 CoilPitch=13 EndAdjustment=0mm BaseInnerRadius=0mm TipInnerDiameter=0mm EndClearance=0mm CoilWrap=0mm SlotLiner=0mm WedgeThickness=0mm LayerInsulation=0mm BottomInsulation=0mm LimitedFillFactor=0.75 WdgNumberofPriodicMultipler=1 NumberOfStrands=36 WireWrap=5mm InterturnInsulation=0mm WireDiameter=2mm WireWidth=0mm WireThickness=0mm Gauge=0
  Rotor Slot: Hs0=0.5mm Hs1=0.66mm Hs2=14mm Bs0=1mm Bs1=12mm Bs2=21mm Rs=0.5mm Hs01=0mm
  Rotor Winding: BarConductorType=magnesium EndLength=0mm EndRingWidth=60mm EndRingHeight=20mm EndRingConductorType=magnesium
  Rotor Vent: VentDucts=0 DuctWidth=0mm MagneticSpacerWidth=0mm DuctPitch=0mm HolesperRow=6 InnerHoleDiameter=30mm OuterHoleDiameter=45mm InnerHoleLocation=300mm OuterHoleLocation=400mm
setups:
  Setup1: TPIM Motor RatedOutputPower=5kW RatedVoltage=230V RatedSpeed=490rpm OperatingTemperature=40cel LoadType=ConstPower Frequency=50Hz WindingConnection=0
reports:
  Torque: OutputTorque vs RSpeed on Setup1 : Performance
  Percentage: Efficiency vs RSpeed on Setup1 : Performance

design Maxwell2DDesign1 (Maxwell 2D, Transient, XY geometry, model units mm)
options: ModelDepth=258.6mm
variables:
  fractions = 1
geometry:
  Band [vacuum] = user_primitive(RMxprt/Band, DiaGap=999.95mm, DiaYoke=200mm, Length=0mm, SegAngle=0deg, Fractions=1, HalfAxial=0, InfoCore=0)
  Shaft [vacuum] = user_primitive(RMxprt/Band, DiaGap=999.95mm, DiaYoke=200mm, Length=0mm, SegAngle=0deg, Fractions=1, HalfAxial=0, InfoCore=100)
  OuterRegion [vacuum] = user_primitive(RMxprt/Band, DiaGap=999.95mm, DiaYoke=1150mm, Length=0mm, SegAngle=0deg, Fractions=fractions, HalfAxial=0, InfoCore=100)
  Tool = user_primitive(RMxprt/Band, DiaGap=999.95mm, DiaYoke=1150mm, Length=0mm, SegAngle=0deg, Fractions=fractions, HalfAxial=0, InfoCore=1)
  Stator [steel_1008_2DSF1.009] = user_primitive(RMxprt/SlotCore, DiaGap=1000mm, DiaYoke=1150mm, Length=0mm, Skew=0deg, Slots=36, SlotType=4, Hs0=0.8mm, Hs01=0mm, Hs1=0.58mm, Hs2=18mm, Bs0=2mm, Bs1=13mm, Bs2=19mm, Rs=6.33mm, FilletType=0, HalfSlot=0, SegAngle=15deg, LenRegion=0mm, InfoCore=0)
  Coil_0 [copper] = user_primitive(RMxprt/LapCoil, DiaGap=1000mm, DiaYoke=1150mm, Length=0mm, Skew=0deg, Slots=36, SlotType=4, Hs0=0.8mm, Hs1=0.58mm, Hs2=18mm, Bs0=2mm, Bs1=13mm, Bs2=19mm, Rs=6.33mm, FilletType=0, Layers=1, CoilPitch=13, EndExt=0mm, SpanExt=0mm, BendAngle=0deg, SegAngle=10deg, LenRegion=0mm, InfoCoil=2)
  Coil_1..Coil_35 [copper] = Coil_0.duplicate_around_axis(axis=Z, angle=10deg, total=36)
  Rotor [steel_1008_2DSF0.970] = user_primitive(RMxprt/VentSlotCore, DiaGap=999.9mm, DiaYoke=200mm, Length=0mm, Skew=0deg, Slots=49, SlotType=2, Hs0=0.5mm, Hs01=0mm, Hs1=0.66mm, Hs2=14mm, Bs0=1mm, Bs1=12mm, Bs2=21mm, Rs=0.5mm, FilletType=0, HalfSlot=0, VentHoles=6, HoleDiaIn=30mm, HoleDiaOut=45mm, HoleLocIn=300mm, HoleLocOut=400mm, VentDucts=0, DuctWidth=0mm, DuctPitch=0mm, SegAngle=15deg, LenRegion=0mm, InfoCore=0)
  Bar [magnesium_40C] = user_primitive(RMxprt/SquirrelCage, DiaGap=999.9mm, DiaYoke=200mm, Length=0mm, Skew=0deg, Slots=49, SlotType=2, Hs0=0.5mm, Hs01=0mm, Hs1=0.66mm, Hs2=14mm, Bs0=1mm, Bs1=12mm, Bs2=21mm, Rs=0.5mm, FilletType=0, HalfSlot=0, BarEndExt=0mm, RingLength=60mm, RingHeight=20mm, RingDiaGap=0mm, CastRotor=1, SegAngle=15deg, LenRegion=0mm, InfoCoil=0)
  Tool_1 = Tool.copy()
  Bar.subtract(Tool_1)
  Bar_Separate1..Bar_Separate48 [magnesium_40C] = Bar.separate_bodies()
  InnerRegion [vacuum] = user_primitive(RMxprt/VentSlotCore, DiaGap=999.9mm, DiaYoke=200mm, Length=0mm, Skew=0deg, Slots=49, SlotType=2, Hs0=0.5mm, Hs01=0mm, Hs1=0.66mm, Hs2=14mm, Bs0=1mm, Bs1=12mm, Bs2=21mm, Rs=0.5mm, FilletType=0, HalfSlot=0, VentHoles=6, HoleDiaIn=30mm, HoleDiaOut=45mm, HoleLocIn=300mm, HoleLocOut=400mm, VentDucts=0, DuctWidth=0mm, DuctPitch=0mm, SegAngle=15deg, LenRegion=0mm, InfoCore=100)
  Tool_2 = Tool.copy()
  Band.subtract(Tool_2)
  Tool_3 = Tool.copy()
  InnerRegion.subtract(Tool_3)
  Tool_4 = Tool.copy()
  Shaft.subtract(Tool_4)
  Tool_5 = Tool.copy()
  Stator.subtract(Tool_5)
  Tool_6 = Tool.copy()
  Coil_0.subtract(Tool_6)
  Tool_7 = Tool.copy()
  Coil_1.subtract(Tool_7)
  Tool_8 = Tool.copy()
  Coil_2.subtract(Tool_8)
  Tool_9 = Tool.copy()
  Coil_3.subtract(Tool_9)
  Tool_10 = Tool.copy()
  Coil_4.subtract(Tool_10)
  Tool_11 = Tool.copy()
  Coil_5.subtract(Tool_11)
  Tool_12 = Tool.copy()
  Coil_6.subtract(Tool_12)
  Tool_13 = Tool.copy()
  Coil_7.subtract(Tool_13)
  Tool_14 = Tool.copy()
  Coil_8.subtract(Tool_14)
  Tool_15 = Tool.copy()
  Coil_9.subtract(Tool_15)
  Tool_16 = Tool.copy()
  Coil_10.subtract(Tool_16)
  Tool_17 = Tool.copy()
  Coil_11.subtract(Tool_17)
  Tool_18 = Tool.copy()
  Coil_12.subtract(Tool_18)
  Tool_19 = Tool.copy()
  Coil_13.subtract(Tool_19)
  Tool_20 = Tool.copy()
  Coil_14.subtract(Tool_20)
  Tool_21 = Tool.copy()
  Coil_15.subtract(Tool_21)
  Tool_22 = Tool.copy()
  Coil_16.subtract(Tool_22)
  Tool_23 = Tool.copy()
  Coil_17.subtract(Tool_23)
  Tool_24 = Tool.copy()
  Coil_18.subtract(Tool_24)
  Tool_25 = Tool.copy()
  Coil_19.subtract(Tool_25)
  Tool_26 = Tool.copy()
  Coil_20.subtract(Tool_26)
  Tool_27 = Tool.copy()
  Coil_21.subtract(Tool_27)
  Tool_28 = Tool.copy()
  Coil_22.subtract(Tool_28)
  Tool_29 = Tool.copy()
  Coil_23.subtract(Tool_29)
  Tool_30 = Tool.copy()
  Coil_24.subtract(Tool_30)
  Tool_31 = Tool.copy()
  Coil_25.subtract(Tool_31)
  Tool_32 = Tool.copy()
  Coil_26.subtract(Tool_32)
  Tool_33 = Tool.copy()
  Coil_27.subtract(Tool_33)
  Tool_34 = Tool.copy()
  Coil_28.subtract(Tool_34)
  Tool_35 = Tool.copy()
  Coil_29.subtract(Tool_35)
  Tool_36 = Tool.copy()
  Coil_30.subtract(Tool_36)
  Tool_37 = Tool.copy()
  Coil_31.subtract(Tool_37)
  Tool_38 = Tool.copy()
  Coil_32.subtract(Tool_38)
  Tool_39 = Tool.copy()
  Coil_33.subtract(Tool_39)
  Tool_40 = Tool.copy()
  Coil_34.subtract(Tool_40)
  Tool_41 = Tool.copy()
  Coil_35.subtract(Tool_41)
  Rotor.subtract(Tool)
motion:
  MotionSetup1: Band Move_Type=Rotate Coordinate_System=Global Axis=Z Is_Positive=true InitPos=0deg Angular_Velocity=492.132rpm Objects=Band
  Moving1: Moving Objects=[Shaft, Rotor, Bar, Bar_Separate1..Bar_Separate48, InnerRegion]
boundaries and excitations:
  VectorPotential1: Vector Potential Edges=OuterRegion.edge(at (0, 575, 0)) Value=0
  PhA_0: Coil Objects=Coil_0 Conductor_number=39 Winding=PhaseA PolarityType=Positive
  PhARe_0: Coil Objects=Coil_3 Conductor_number=39 Winding=PhaseA PolarityType=Negative
  PhB_1: Coil Objects=Coil_2 Conductor_number=39 Winding=PhaseB PolarityType=Positive
  PhBRe_1: Coil Objects=Coil_5 Conductor_number=39 Winding=PhaseB PolarityType=Negative
  PhC_2: Coil Objects=Coil_4 Conductor_number=39 Winding=PhaseC PolarityType=Positive
  PhCRe_2: Coil Objects=Coil_7 Conductor_number=39 Winding=PhaseC PolarityType=Negative
  PhA_3: Coil Objects=Coil_6 Conductor_number=39 Winding=PhaseA PolarityType=Positive
  PhARe_3: Coil Objects=Coil_9 Conductor_number=39 Winding=PhaseA PolarityType=Negative
  PhB_4: Coil Objects=Coil_8 Conductor_number=39 Winding=PhaseB PolarityType=Positive
  PhBRe_4: Coil Objects=Coil_11 Conductor_number=39 Winding=PhaseB PolarityType=Negative
  PhC_5: Coil Objects=Coil_10 Conductor_number=39 Winding=PhaseC PolarityType=Positive
  PhCRe_5: Coil Objects=Coil_13 Conductor_number=39 Winding=PhaseC PolarityType=Negative
  PhA_6: Coil Objects=Coil_12 Conductor_number=39 Winding=PhaseA PolarityType=Positive
  PhARe_6: Coil Objects=Coil_15 Conductor_number=39 Winding=PhaseA PolarityType=Negative
  PhB_7: Coil Objects=Coil_14 Conductor_number=39 Winding=PhaseB PolarityType=Positive
  PhBRe_7: Coil Objects=Coil_17 Conductor_number=39 Winding=PhaseB PolarityType=Negative
  PhC_8: Coil Objects=Coil_16 Conductor_number=39 Winding=PhaseC PolarityType=Positive
  PhCRe_8: Coil Objects=Coil_19 Conductor_number=39 Winding=PhaseC PolarityType=Negative
  PhA_9: Coil Objects=Coil_18 Conductor_number=39 Winding=PhaseA PolarityType=Positive
  PhARe_9: Coil Objects=Coil_21 Conductor_number=39 Winding=PhaseA PolarityType=Negative
  PhB_10: Coil Objects=Coil_20 Conductor_number=39 Winding=PhaseB PolarityType=Positive
  PhBRe_10: Coil Objects=Coil_23 Conductor_number=39 Winding=PhaseB PolarityType=Negative
  PhC_11: Coil Objects=Coil_22 Conductor_number=39 Winding=PhaseC PolarityType=Positive
  PhCRe_11: Coil Objects=Coil_25 Conductor_number=39 Winding=PhaseC PolarityType=Negative
  PhA_12: Coil Objects=Coil_24 Conductor_number=39 Winding=PhaseA PolarityType=Positive
  PhARe_12: Coil Objects=Coil_27 Conductor_number=39 Winding=PhaseA PolarityType=Negative
  PhB_13: Coil Objects=Coil_26 Conductor_number=39 Winding=PhaseB PolarityType=Positive
  PhBRe_13: Coil Objects=Coil_29 Conductor_number=39 Winding=PhaseB PolarityType=Negative
  PhC_14: Coil Objects=Coil_28 Conductor_number=39 Winding=PhaseC PolarityType=Positive
  PhCRe_14: Coil Objects=Coil_31 Conductor_number=39 Winding=PhaseC PolarityType=Negative
  PhA_15: Coil Objects=Coil_30 Conductor_number=39 Winding=PhaseA PolarityType=Positive
  PhARe_15: Coil Objects=Coil_33 Conductor_number=39 Winding=PhaseA PolarityType=Negative
  PhB_16: Coil Objects=Coil_32 Conductor_number=39 Winding=PhaseB PolarityType=Positive
  PhBRe_16: Coil Objects=Coil_35 Conductor_number=39 Winding=PhaseB PolarityType=Negative
  PhC_17: Coil Objects=Coil_34 Conductor_number=39 Winding=PhaseC PolarityType=Positive
  PhCRe_17: Coil Objects=Coil_1 Conductor_number=39 Winding=PhaseC PolarityType=Negative
  EndConnection1: End Connection Objects=[Bar, Bar_Separate1..Bar_Separate48] ResistanceValue=2.06205e-05ohm InductanceValue=1.01665e-08H
  PhaseA: Winding Group Type=Voltage IsSolid=false Current=0A Resistance=0.00122765ohm Inductance=0.000107717H Voltage=187.794*sin(2*pi*50*time) ParallelBranchesNum=6
  PhaseB: Winding Group Type=Voltage IsSolid=false Current=0A Resistance=0.00122765ohm Inductance=0.000107717H Voltage=187.794*sin(2*pi*50*time-2*pi/3) ParallelBranchesNum=6
  PhaseC: Winding Group Type=Voltage IsSolid=false Current=0A Resistance=0.00122765ohm Inductance=0.000107717H Voltage=187.794*sin(2*pi*50*time-4*pi/3) ParallelBranchesNum=6
  Y connection: PhaseA, PhaseB, PhaseC
mesh:
  SurfApprox_Bar: SurfApproxBased Objects=[Bar, Bar_Separate1..Bar_Separate48] CurvedSurfaceApproxChoice=ManualSettings SurfDev=0.49995mm NormalDev=15deg
  SurfApprox_Main: SurfApproxBased Objects=[Stator, Rotor, Band, OuterRegion, InnerRegion, Shaft] CurvedSurfaceApproxChoice=ManualSettings SurfDev=0.575mm NormalDev=15deg
  initial mesh: MeshMethod=AnsoftTAU
setups:
  Setup1: Transient NonlinearSolverResidual=0.0001 StopTime=0.2s TimeStep=0.0002s FastReachSteadyState AutoDetectSteadyState FrequencyOfAddedVoltageSource=50Hz StopCriterion=0.005 InitialTimeStep=0.002s MinTimeStep=0.001s MaxTimeStep=0.003s TimeStepErrTolerance=0.0001
reports:
  Torque: Moving1.Torque vs Time on Setup1 : Transient
  Currents: Current(PhaseA), Current(PhaseB), Current(PhaseC) vs Time on Setup1 : Transient
  Induced Voltages: InducedVoltage(PhaseA), InducedVoltage(PhaseB), InducedVoltage(PhaseC) vs Time on Setup1 : Transient
  Flux Linkages: FluxLinkage(PhaseA), FluxLinkage(PhaseB), FluxLinkage(PhaseC) vs Time on Setup1 : Transient
  Voltages: InputVoltage(PhaseA), InputVoltage(PhaseB), InputVoltage(PhaseC) vs Time on Setup1 : Transient
  Powers: InputVoltage(PhaseA)*Current(PhaseA) + InputVoltage(PhaseB)*Current(PhaseB) + InputVoltage(PhaseC)*Current(PhaseC), Moving1.Speed*Moving1.Torque vs Time on Setup1 : Transient
